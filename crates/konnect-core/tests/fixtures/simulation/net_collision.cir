.title KiCad schematic
.include "/fixture/fx-run1/coll/diode.mod"
.tran 1u 10m

R1 /A_1_ Net-_D1-A_ 1k
D1 Net-_D1-A_ /A_1_ 1N4148
V1 /A_1_ GND DC 0 SIN( 0 1 1k 0 0 0 ) AC 1
C1 /A_1_ GND 100n
R2 /A_1_ GND 100k
.end
