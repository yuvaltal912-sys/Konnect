.title konnect simulation
V1 /in 0 DC 3
R1 /in /out 1k
R2 /out 0 2k
.op
.end
