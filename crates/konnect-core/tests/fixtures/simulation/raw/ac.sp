.title konnect simulation
V1 /in 0 DC 0 AC 1
R1 /in /out 1k
C1 /out 0 100n
.ac dec 3 10 100k
.end
