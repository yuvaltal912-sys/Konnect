.title konnect simulation
V1 /in 0 DC 0
V2 /b 0 DC 0
R1 /in /out 1k
R2 /out /b 1k
.dc V1 0 2 1 V2 0 1 1
.end
