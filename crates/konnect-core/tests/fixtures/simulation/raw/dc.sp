.title konnect simulation
V1 /in 0 DC 0
R1 /in /out 1k
R2 /out 0 1k
.dc V1 0 4 1
.end
