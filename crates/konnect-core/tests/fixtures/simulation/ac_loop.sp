* A loop gain of three real poles, at 100 Hz, 1 kHz and 10 kHz, with a DC gain of 100.
VIN in 0 DC 0 AC 1
R1 in a 1k
C1 a 0 1.5915494309189535u
E1 b 0 a 0 1
R2 b c 1k
C2 c 0 159.15494309189535n
E2 d 0 c 0 1
R3 d e 1k
C3 e 0 15.915494309189535n
E3 out 0 e 0 100
RLOAD out 0 1Meg
